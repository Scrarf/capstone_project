* EIT ADC front end (OPA810 follower) - reference ngspice netlist, identical to adc_frontend.sch
* Run: ngspice adc_frontend.cir   (needs 'set ngbehavior=psa' in .spiceinit for the TI OPA810 model)
V1 vcc 0 DC 24
V2 v33 0 DC 3.3
R1 vf vcc 1k
C1 0 vf 10u
V3 src ms DC 0 AC 1
B1 ms 0 V = 3.1368e-2*(sin(6.283185e+04*time+-0.000000)+sin(1.256637e+05*time+-0.125664)+sin(1.884956e+05*time+-0.376991)+sin(2.513274e+05*time+-0.753982)+sin(3.141593e+05*time+-1.256637)+sin(3.769911e+05*time+-1.884956)+sin(4.398230e+05*time+-2.638938)+sin(5.026548e+05*time+-3.518584)+sin(5.654867e+05*time+-4.523893)+sin(6.283185e+05*time+-5.654867)+sin(6.911504e+05*time+-6.911504)+sin(7.539822e+05*time+-8.293805)+sin(8.168141e+05*time+-9.801769)+sin(8.796459e+05*time+-11.435397)+sin(9.424778e+05*time+-13.194689)+sin(1.005310e+06*time+-15.079645)+sin(1.068142e+06*time+-17.090264)+sin(1.130973e+06*time+-19.226547)+sin(1.193805e+06*time+-21.488494)+sin(1.256637e+06*time+-23.876104)+sin(1.319469e+06*time+-26.389378)+sin(1.382301e+06*time+-29.028316)+sin(1.445133e+06*time+-31.792918)+sin(1.507964e+06*time+-34.683183)+sin(1.570796e+06*time+-37.699112)+sin(1.633628e+06*time+-40.840704)+sin(1.696460e+06*time+-44.107961)+sin(1.759292e+06*time+-47.500881)+sin(1.822124e+06*time+-51.019465)+sin(1.884956e+06*time+-54.663712)+sin(1.947787e+06*time+-58.433623)+sin(2.010619e+06*time+-62.329198)+sin(2.073451e+06*time+-66.350437)+sin(2.136283e+06*time+-70.497339)+sin(2.199115e+06*time+-74.769905)+sin(2.261947e+06*time+-79.168135)+sin(2.324779e+06*time+-83.692028)+sin(2.387610e+06*time+-88.341585)+sin(2.450442e+06*time+-93.116806)+sin(2.513274e+06*time+-98.017691)+sin(2.576106e+06*time+-103.044239)+sin(2.638938e+06*time+-108.196451)+sin(2.701770e+06*time+-113.474327)+sin(2.764602e+06*time+-118.877866)+sin(2.827433e+06*time+-124.407069)+sin(2.890265e+06*time+-130.061936)+sin(2.953097e+06*time+-135.842466)+sin(3.015929e+06*time+-141.748661)+sin(3.078761e+06*time+-147.780518)+sin(3.141593e+06*time+-153.938040))
R2 src elec 1Meg
C2 src elec 0.3n
C3 elec nb 1n
R3 nb vf 22Meg
R4 0 nb 22Meg
.INCLUDE "opa810_a.lib"
XX1 nb out out vcc 0 OPA810
C4 out aa 470n
R5 aa pa 7k
R6 pa v33 2k
R7 0 pa 2k
C5 0 pa 100p
R8 pa adca 1k
C6 0 adca 4p
C7 out ab 470n
R9 ab pb 3k
R10 pb v33 3k
R11 0 pb 3k
C8 0 pb 100p
D1 pb v33 DMOD_D1 AREA=1.0
.MODEL DMOD_D1 D (Is=2.2e-7 N=1.04 Cj0=11.5p M=0.33 Vj=0.38 Fc=0.5 Rs=0.94 Tt=0.0p Kf=0.0 Af=1.0 Bv=30 Ibv=10u Xti=3.0 Eg=1.11 Tcv=0.0 Trs=0.0 Ttt1=0.0 Ttt2=0.0 Tm1=0.0 Tm2=0.0 Tnom=26.85)
D2 0 pb DMOD_D2 AREA=1.0
.MODEL DMOD_D2 D (Is=2.2e-7 N=1.04 Cj0=11.5p M=0.33 Vj=0.38 Fc=0.5 Rs=0.94 Tt=0.0p Kf=0.0 Af=1.0 Bv=30 Ibv=10u Xti=3.0 Eg=1.11 Tcv=0.0 Trs=0.0 Ttt1=0.0 Ttt2=0.0 Tm1=0.0 Tm2=0.0 Tnom=26.85)
R12 pb adcb 1k
C9 0 adcb 4p
C10 out ac 470n
R13 ac pc 1k
R14 pc v33 20k
R15 0 pc 20k
C11 0 pc 100p
D3 pc v33 DMOD_D3 AREA=1.0
.MODEL DMOD_D3 D (Is=2.2e-7 N=1.04 Cj0=11.5p M=0.33 Vj=0.38 Fc=0.5 Rs=0.94 Tt=0.0p Kf=0.0 Af=1.0 Bv=30 Ibv=10u Xti=3.0 Eg=1.11 Tcv=0.0 Trs=0.0 Ttt1=0.0 Ttt2=0.0 Tm1=0.0 Tm2=0.0 Tnom=26.85)
D4 0 pc DMOD_D4 AREA=1.0
.MODEL DMOD_D4 D (Is=2.2e-7 N=1.04 Cj0=11.5p M=0.33 Vj=0.38 Fc=0.5 Rs=0.94 Tt=0.0p Kf=0.0 Af=1.0 Bv=30 Ibv=10u Xti=3.0 Eg=1.11 Tcv=0.0 Trs=0.0 Ttt1=0.0 Ttt2=0.0 Tm1=0.0 Tm2=0.0 Tnom=26.85)
R16 pc adcc 1k
C12 0 adcc 4p
.control
op
print v(nb) v(out) v(pa) v(pb) v(pc) i(V1)
ac dec 100 100 20Meg
let ga = v(pa)*8
let gb = v(pb)*3
let gc = v(pc)*1.1
meas ac pa_db_10k find vdb(ga) at=10k
meas ac pa_ph_10k find vp(ga) at=10k
meas ac pa_db_500k find vdb(ga) at=500k
meas ac pa_ph_500k find vp(ga) at=500k
meas ac pb_db_500k find vdb(gb) at=500k
meas ac pb_ph_500k find vp(gb) at=500k
meas ac pc_db_500k find vdb(gc) at=500k
meas ac pc_ph_500k find vp(gc) at=500k
tran 5n 300u 0 5n
meas tran out_min min v(out) from=200u to=300u
meas tran out_max max v(out) from=200u to=300u
meas tran pa_min min v(pa) from=200u to=300u
meas tran pa_max max v(pa) from=200u to=300u
.endc
.end
